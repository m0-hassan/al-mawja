** Profile: "SCHEMATIC1-TransientAnalysis"  [ C:\Users\a0232073\Desktop\GWL_Models\THS4551\AppendScript\THS4551-PSpiceFiles\SCHEMATIC1\TransientAnalysis.sim ]

** Creating circuit file "TransientAnalysis.cir"
** WARNING: THIS AUTOMATICALLY GENERATED FILE MAY BE OVERWRITTEN BY SUBSEQUENT SIMULATIONS

*Libraries:
* Profile Libraries :
* Local Libraries :
.LIB "../../../THS4551.lib"
* From [PSPICE NETLIST] section of C:\SPB_Data\cdssetup\OrCAD_PSpiceTIPSpice_Install\17.4.0\PSpice.ini file:
.lib "nom_pspti.lib"
.lib "nom.lib"

*Analysis directives:
.TRAN  0 100ns 0 0.1e-9
.OPTIONS ADVCONV
.OPTIONS FILEMODELSEARCH
.PROBE64 N([OUT-])
.PROBE64 N([OUT+])
.INC "..\SCHEMATIC1.net"

.END
